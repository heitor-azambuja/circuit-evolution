.model 2n2222a NPN(IS=3.88184e-14 BF=929.846 NF=1.10496 VAF=16.5003 IKF=0.019539 ISE=1.0168e-11 NE=1.94752 BR=48.4545 NR=1.07004 VAR=40.538 IKR=0.19539 ISC=1.0168e-11 NC=4 RB=0.1 IRB=0.1 RBM=0.1 RE=0.0001 RC=0.426673 XTB=0.1 XTI=1 EG=1.05 CJE=2.23677e-11 VJE=0.582701 MJE=0.63466 TF=4.06711e-10 XTF=3.92912 VTF=17712.6 ITF=0.4334 CJC=2.23943e-11 VJC=0.576146 MJC=0.632796 XCJC=1 FC=0.170253 CJS=0 VJS=0.75 MJS=0.5 TR=1e-07 PTF=0 KF=0 AF=1)

.model bc547b NPN(IS=2.39E-14 NF=1.008 ISE=3.545E-15 NE=1.541 BF=294.3 IKF=0.1357 VAF=63.2 NR=1.004 ISC=6.272E-14 NC=1.243 BR=7.946 IKR=0.1144 VAR=25.9 RB=1 IRB=1.00E-06 RBM=1 RE=0.4683 RC=0.85 XTB=0 EG=1.11 XTI=3 CJE=1.358E-11 VJE=0.65 MJE=0.3279 TF=4.391E-10 XTF=120 VTF=2.643 ITF=0.7495 PTF=0 CJC=3.728E-12 VJC=0.3997 MJC=0.2955 XCJC=0.6193 TR=1.00E-32 CJS=0 VJS=0.75 MJS=0.333 FC=0.9579 Vceo=45 Icrating=100m mfg=Philips)

.model bc547c NPN(IS=4.679E-14 NF=1.01 ISE=2.642E-15 NE=1.581 BF=458.7 IKF=0.1371 VAF=52.64 NR=1.019 ISC=2.337E-14 NC=1.164 BR=11.57 IKR=0.1144 VAR=364.5 RB=1 IRB=1.00E-06 RBM=1 RE=0.2598 RC=1 XTB=0 EG=1.11 XTI=3 CJE=1.229E-11 VJE=0.5591 MJE=0.3385 TF=4.689E-10 XTF=160 VTF=2.828 ITF=0.8842 PTF=0 CJC=4.42E-12 VJC=0.1994 MJC=0.2782 XCJC=0.6193 TR=1.00E-32 CJS=0 VJS=0.75 MJS=0.333 FC=0.7936 Vceo=45 Icrating=100m mfg=Philips)

.model bc557b PNP(IS=3.83E-14 NF=1.008 ISE=1.22E-14 NE=1.528 BF=344.4 IKF=0.08039 VAF=21.11 NR=1.005 ISC=2.85E-13 NC=1.28 BR=14.84 IKR=0.047 VAR=32.02 RB=1 IRB=1.00E-06 RBM=1 RE=0.6202 RC=0.5713 XTB=0 EG=1.11 XTI=3 CJE=1.23E-11 VJE=0.6106 MJE=0.378 TF=5.60E-10 XTF=3.414 VTF=5.23 ITF=0.1483 PTF=0 CJC=1.08E-11 VJC=0.1022 MJC=0.3563 XCJC=0.6288 TR=1.00E-32 CJS=0 VJS=0.75 MJS=0.333 FC=0.8027 Vceo=45 Icrating=100m mfg=Philips)

.model bc557c PNP(IS=5.83E-14 NF=1.009 ISE=3.88E-15 NE=1.408 BF=516.7 IKF=0.08039 VAF=26.03 NR=1.006 ISC=4.01E-14 NC=1.313 BR=12.45 IKR=0.07238 VAR=6.717 RB=1 IRB=1.00E-06 RBM=1 RE=0.5685 RC=0.6257 XTB=0 EG=1.11 XTI=3 CJE=1.26E-11 VJE=0.3809 MJE=0.3545 TF=5.23E-10 XTF=4.339 VTF=5.425 ITF=0.1896 PTF=0 CJC=7.80E-12 VJC=0.5897 MJC=0.4569 XCJC=0.6288 TR=1.00E-32 CJS=0 VJS=0.75 MJS=0.333 FC=0.5729 Vceo=45 Icrating=100m mfg=Philips)
